* ================================================================
*  sky130 "4-helper" 8-inverter ring  --  CLOSED-LOOP transient
*  CORRECT topology from the "Result: 4 helpers A3*" sketch:
*    Only 4 nets: alpha(al) beta(be) gamma(ga) delta(de).
*    Distance-1 ring : al->be->ga->de->al   (A1,A2,A4,A5)
*    Distance-2 diags: al->ga, ga->al, be->de, de->be  (A3,A3'',A3',A3''')
*    Each net is driven by 2 inverters (outputs shorted) and drives 2.
* ================================================================
.lib "__LIBPATH__" tt
.include "inv.spice"

.param SUP=1.8
Vdd vdd 0 {SUP}

* --- distance-1 ring ---
Xa1 al be vdd 0 inv       ; A1
Xa2 be ga vdd 0 inv       ; A2
Xa4 ga de vdd 0 inv       ; A4  (black, right)
Xa5 de al vdd 0 inv       ; A5  (black, left)
* --- distance-2 diagonals (the 4 helpers) ---
Xa3 al ga vdd 0 inv       ; A3    (cyan helper)  -> shorted onto gamma
Xa6 ga al vdd 0 inv       ; A3''  (green)        -> shorted onto alpha
Xa8 be de vdd 0 inv       ; A3'   (orange)       -> shorted onto delta
Xa7 de be vdd 0 inv       ; A3''' (red)          -> shorted onto beta

* seed off the metastable point
.ic v(al)=0 v(be)=1.8 v(ga)=1.8 v(de)=0

.control
  tran 1p 20n uic
  wrdata tran_8stage.txt v(al) v(be) v(ga) v(de)
  meas tran t1 when v(al)=0.9 rise=4
  meas tran t2 when v(al)=0.9 rise=6
  let Tosc = (t2 - t1)/2
  let Fosc = 1/Tosc
  print Tosc Fosc
.endc
.end
