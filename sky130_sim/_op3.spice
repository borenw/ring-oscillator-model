.lib "/Users/boren_wang/.volare/volare/sky130/versions/c6d73a35f524070e85faff4a6a9eef49553ebc2b/sky130A/libs.tech/ngspice/sky130.lib.spice" tt
.include "inv.spice"
Vdd vdd 0 1.8
Xi1 n1 n2 vdd 0 inv
Xi2 n2 n3 vdd 0 inv
Xi3 n3 n3o vdd 0 inv
Lbrk n3o n1 1e6
.control
op
print v(n1) v(n2) v(n3)
* small-signal output resistance of one inverter at the trip point:
* drive its output, measure; use the .op device info instead
.endc
.end
