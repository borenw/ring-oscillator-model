.lib "/Users/boren_wang/.volare/volare/sky130/versions/c6d73a35f524070e85faff4a6a9eef49553ebc2b/sky130A/libs.tech/ngspice/sky130.lib.spice" tt
.include "inv.spice"
Vdd vdd 0 1.8
* self-bias to trip: input tied to output through big L (DC), output = node o
Xinv o o vdd 0 inv
* inject AC current at output, input follows at DC via the self-tie; measure Z=V/I
Iac o 0 dc 0 ac 1
.control
op
print v(o)
ac dec 10 1e3 1e6
let ro = v(o)/1        ; I=1A so Z=V
print v(o)[0]
.endc
.end
